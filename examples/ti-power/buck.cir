* TPS54320: 12 V input, nominal 3.3 V / 3 A, EVM component values
.include TPS54320
.temp 25
VINPUT VIN 0 PWL(0 0 100u 12)
XU BOOT COMP EN 0 0 0 PH PH VIN VIN PG RT SS VIN VSENSE TPS54320_TRANS
C2 VIN 0 4.7u
C3 VIN 0 4.7u
C4 CZ 0 15n
C5 BOOT PH 100n
C6 COMP 0 330p
C7 SS 0 10n
C9 OUT 0 47u
C11 FBTOP VSENSE 100p
RDCR PH LX 0.024
L1 LX OUT 6.8u
R1 VIN EN 511k
R2 EN 0 100k
R3 RT 0 100k
R4 COMP CZ 1.78k
R7 OUT FBTOP 51.1
R8 FBTOP VSENSE 31.6k
R9 VSENSE 0 10k
R10 OUT PG 100k
RLOAD OUT 0 1.1
.options interp
.SAVE V(OUT)
.PRINT TRAN V(OUT)
.tran 50n 5m 0 50n UIC
.end
