* Desktop tscircuit 0.0.3247, attempt 2: buck-load-step
.include TPS54320
CC2 N2 0 4.7U
CC3 N2 0 4.7U
CC4 N10 0 14.999999999999998N
CC5 N8 N7 100N
CC6 N4 0 330P
CC7 N5 0 10N
CC9 N11 0 47U
CC11 N12 N3 100P
LL1 N7 N11 6.8uH
RR1 N2 N6 511K
RR2 N6 0 100K
RR3 N1 0 100K
RR4 N4 N10 1.78K
RR7 N11 N12 51.1
RR8 N12 N3 31.6K
RR9 N3 0 10K
Vsimulation_voltage_source_0 N2 0 DC 12
Isimulation_current_source_0 N11 0 PULSE(0 0.75 0 1n 1n 0.001 0.002)
Xsimulation_spice_subcircuit_0 N8 N4 N6 0 0 0 N7 N7 N2 N2 N9 N1 N5 N2 N3 TPS54320_TRANS
.PRINT TRAN V(N11)
.SAVE V(N11)
.tran 5e-8 0.008 UIC
.END
