* Desktop four-stage power-tree reproduction, including its startup setup
.include LMZM33602
.include TPS82130
.include TPS82084
.include TPS82085
VINPUT v24 0 PWL(0 0 1m 24)
X1 ag d1 d2 v24 fb1 0 0 0 0 pg1 rt sw sw sw v24 v12 v12 v12 LMZM33602_TRANS
Rrt rt ag 44.2k
R1t v12 fb1 110k
R1b fb1 ag 10k
X2 v12 0 fb2 0 pg2 ss v12 v5 v5 TPS82130_TRANS SS=1
Css ss 0 3.3n
R2t v5 fb2 525k
R2b fb2 0 100k
X3 v5 fb3 0 0 pg3 v5 v5 v1v2 0 TPS82084_TRANS SS=1
Rt3 v1v2 fb3 50k
Rb3 fb3 0 100k
X4 v5 fb4 0 0 pg4 v5 v5 v1v8 0 TPS82085_TRANS SS=1
Rt4 v1v8 fb4 125k
Rb4 fb4 0 100k
C0 v24 0 10u
C1 v12 0 57u
C2 v5 0 67u
C3 v1v2 0 22u
C4 v1v8 0 22u
I1 v1v2 0 PULSE(0.5 1 10m 10u 10u 5m 10m)
I2 v1v8 0 PULSE(0.75 1.5 10m 10u 10u 5m 10m)
.options method=gear reltol=0.003 interp
.SAVE V(v12) V(v5) V(v1v2) V(v1v8)
.PRINT TRAN V(v12) V(v5) V(v1v2) V(v1v8)
.tran 1u 25m
.end
