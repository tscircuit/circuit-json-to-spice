* Desktop tscircuit 0.0.3247, attempt 2: tree-load-steps
.include LMZM33602
.include TPS82130
.include TPS82084
.include TPS82085
RR1T VP_12V N2 110K
RR1B N2 0 10K
CC1IN N1 0 10U
CC1OUT VP_12V 0 47U
RR2T VP_5V N3 523K
RR2B N3 0 100K
CC2IN VP_12V 0 10U
CC2OUT VP_5V 0 47U
CCSS N4 0 10N
RR3T VP_1V2 N5 100K
RR3B N5 0 100K
CC3IN VP_5V 0 10U
CC3OUT VP_1V2 0 47U
RR4T VP_1V8 N6 200K
RR4B N6 0 100K
CC4IN VP_5V 0 10U
CC4OUT VP_1V8 0 47U
Xsimulation_spice_subcircuit_0 0 N11 N12 N1 N2 0 0 0 0 N13 N7 N8 N9 N10 N1 VP_12V VP_12V VP_12V LMZM33602_TRANS
Xsimulation_spice_subcircuit_1 VP_12V 0 N3 0 N14 N4 VP_12V VP_5V VP_5V TPS82130_TRANS
Xsimulation_spice_subcircuit_2 VP_5V N5 0 0 N15 VP_5V VP_5V VP_1V2 0 TPS82084_TRANS
Xsimulation_spice_subcircuit_3 VP_5V N6 0 0 N16 VP_5V VP_5V VP_1V8 0 TPS82085_TRANS
VINPUT N1 0 PULSE(0 24 1m 1m 1u 100m 200m)
I1 VP_1V2 0 PULSE(0.5 1 20m 10u 10u 10m 20m)
I2 VP_1V8 0 PULSE(0.75 1.5 20m 10u 10u 10m 20m)
.PRINT TRAN V(VP_12V) V(VP_5V) V(VP_1V2) V(VP_1V8)
.SAVE V(VP_12V) V(VP_5V) V(VP_1V2) V(VP_1V8)
.tran 0.000002 0.06 UIC
.END
